* original design ESP8266 stress_50pct weak
Vgb src 0 5.0
Rsrc src gb 2.0
Cgb gb 0 0.0001
Igb gb 0 0.1
* NCP1117: output tracks min(3.3, Vin-1.1), current limit 1A, 5mA ground current. Input current = output current.
Bldo gb v33 I = max(0, min(1.0, 20*(min(3.3, V(gb)-1.1) - V(v33)))) + 0.005
C680 v33 c680n 680u
Resr680 c680n 0 0.4
C100 v33 c100n 100u
Resr100 c100n 0 1.4
C10 v33 0 10u
Iesp v33 0 PWL(0.000000 0.0000 0.020000 0.0000 0.020001 0.0700 0.021000 0.0700 0.021005 0.1700 0.022000 0.1700 0.022005 0.0700 0.023000 0.0700 0.023005 0.1700 0.024000 0.1700 0.024005 0.0700 0.025000 0.0700 0.025005 0.1700 0.026000 0.1700 0.026005 0.0700 0.027000 0.0700 0.027005 0.1700 0.028000 0.1700 0.028005 0.0700 0.029000 0.0700 0.029005 0.1700 0.030000 0.1700 0.030005 0.0700 0.031000 0.0700 0.031005 0.1700 0.032000 0.1700 0.032005 0.0700 0.033000 0.0700 0.033005 0.1700 0.034000 0.1700 0.034005 0.0700 0.035000 0.0700 0.035005 0.1700 0.036000 0.1700 0.036005 0.0700 0.037000 0.0700 0.037005 0.1700 0.038000 0.1700 0.038005 0.0700 0.039000 0.0700 0.039005 0.1700 0.040000 0.1700 0.040005 0.0700 0.041000 0.0700 0.041005 0.1700 0.042000 0.1700 0.042005 0.0700 0.043000 0.0700 0.043005 0.1700 0.044000 0.1700 0.044005 0.0700 0.045000 0.0700 0.045005 0.1700 0.046000 0.1700 0.046005 0.0700 0.047000 0.0700 0.047005 0.1700 0.048000 0.1700 0.048005 0.0700 0.049000 0.0700 0.049005 0.1700 0.050000 0.1700 0.050005 0.0700 0.051000 0.0700 0.051005 0.1700 0.052000 0.1700 0.052005 0.0700 0.053000 0.0700 0.053005 0.1700 0.054000 0.1700 0.054005 0.0700 0.055000 0.0700 0.055005 0.1700 0.056000 0.1700 0.056005 0.0700 0.057000 0.0700 0.057005 0.1700 0.058000 0.1700 0.058005 0.0700 0.059000 0.0700 0.059005 0.1700 0.060000 0.1700 0.060005 0.0700 0.061000 0.0700 0.061005 0.1700 0.062000 0.1700 0.062005 0.0700 0.063000 0.0700 0.063005 0.1700 0.064000 0.1700 0.064005 0.0700 0.065000 0.0700 0.065005 0.1700 0.066000 0.1700 0.066005 0.0700 0.067000 0.0700 0.067005 0.1700 0.068000 0.1700 0.068005 0.0700 0.069000 0.0700 0.069005 0.1700 0.070000 0.1700 0.070005 0.0700 0.071000 0.0700 0.071005 0.1700 0.072000 0.1700 0.072005 0.0700 0.073000 0.0700 0.073005 0.1700 0.074000 0.1700 0.074005 0.0700 0.075000 0.0700 0.075005 0.1700 0.076000 0.1700 0.076005 0.0700 0.077000 0.0700 0.077005 0.1700 0.078000 0.1700 0.078005 0.0700 0.079000 0.0700 0.079005 0.1700 0.080000 0.1700 0.080005 0.0700 0.081000 0.0700 0.081005 0.1700 0.082000 0.1700 0.082005 0.0700 0.083000 0.0700 0.083005 0.1700 0.084000 0.1700 0.084005 0.0700 0.085000 0.0700 0.085005 0.1700 0.086000 0.1700 0.086005 0.0700 0.087000 0.0700 0.087005 0.1700 0.088000 0.1700 0.088005 0.0700 0.089000 0.0700 0.089005 0.1700 0.090000 0.1700 0.090005 0.0700 0.091000 0.0700 0.091005 0.1700 0.092000 0.1700 0.092005 0.0700 0.093000 0.0700 0.093005 0.1700 0.094000 0.1700 0.094005 0.0700 0.095000 0.0700 0.095005 0.1700 0.096000 0.1700 0.096005 0.0700 0.097000 0.0700 0.097005 0.1700 0.098000 0.1700 0.098005 0.0700 0.099000 0.0700 0.099005 0.1700 0.100000 0.1700 0.100005 0.0700 0.101000 0.0700 0.101005 0.1700 0.102000 0.1700 0.102005 0.0700 0.103000 0.0700 0.103005 0.1700 0.104000 0.1700 0.104005 0.0700 0.105000 0.0700 0.105005 0.1700 0.106000 0.1700 0.106005 0.0700 0.107000 0.0700 0.107005 0.1700 0.108000 0.1700 0.108005 0.0700 0.109000 0.0700 0.109005 0.1700 0.110000 0.1700 0.110005 0.0700 0.111000 0.0700 0.111005 0.1700 0.112000 0.1700 0.112005 0.0700 0.113000 0.0700 0.113005 0.1700 0.114000 0.1700 0.114005 0.0700 0.115000 0.0700 0.115005 0.1700 0.116000 0.1700 0.116005 0.0700 0.117000 0.0700 0.117005 0.1700 0.118000 0.1700 0.118005 0.0700 0.119000 0.0700 0.119005 0.1700 0.120000 0.1700 0.120005 0.0700 0.121000 0.0700 0.121005 0.1700 0.122000 0.1700 0.122005 0.0700 0.123000 0.0700 0.123005 0.1700 0.124000 0.1700 0.124005 0.0700 0.125000 0.0700 0.125005 0.1700 0.126000 0.1700 0.126005 0.0700 0.127000 0.0700 0.127005 0.1700 0.128000 0.1700 0.128005 0.0700 0.129000 0.0700 0.129005 0.1700 0.130000 0.1700 0.130005 0.0700 0.131000 0.0700 0.131005 0.1700 0.132000 0.1700 0.132005 0.0700 0.133000 0.0700 0.133005 0.1700 0.134000 0.1700 0.134005 0.0700 0.135000 0.0700 0.135005 0.1700 0.136000 0.1700 0.136005 0.0700 0.137000 0.0700 0.137005 0.1700 0.138000 0.1700 0.138005 0.0700 0.139000 0.0700 0.139005 0.1700 0.140000 0.1700 0.140005 0.0700 0.141000 0.0700 0.141005 0.1700 0.142000 0.1700 0.142005 0.0700 0.143000 0.0700 0.143005 0.1700 0.144000 0.1700 0.144005 0.0700 0.145000 0.0700 0.145005 0.1700 0.146000 0.1700 0.146005 0.0700 0.147000 0.0700 0.147005 0.1700 0.148000 0.1700 0.148005 0.0700 0.149000 0.0700 0.149005 0.1700 0.150000 0.1700 0.150005 0.0700 0.151000 0.0700 0.151005 0.1700 0.152000 0.1700 0.152005 0.0700 0.153000 0.0700 0.153005 0.1700 0.154000 0.1700 0.154005 0.0700 0.155000 0.0700 0.155005 0.1700 0.156000 0.1700 0.156005 0.0700 0.157000 0.0700 0.157005 0.1700 0.158000 0.1700 0.158005 0.0700 0.159000 0.0700 0.159005 0.1700 0.160000 0.1700 0.160005 0.0700 0.161000 0.0700 0.161005 0.1700 0.162000 0.1700 0.162005 0.0700 0.163000 0.0700 0.163005 0.1700 0.164000 0.1700 0.164005 0.0700 0.165000 0.0700 0.165005 0.1700 0.166000 0.1700 0.166005 0.0700 0.167000 0.0700 0.167005 0.1700 0.168000 0.1700 0.168005 0.0700 0.169000 0.0700 0.169005 0.1700 0.170000 0.1700 0.170005 0.0700 0.171000 0.0700 0.171005 0.1700 0.172000 0.1700 0.172005 0.0700 0.173000 0.0700 0.173005 0.1700 0.174000 0.1700 0.174005 0.0700 0.175000 0.0700 0.175005 0.1700 0.176000 0.1700 0.176005 0.0700 0.177000 0.0700 0.177005 0.1700 0.178000 0.1700 0.178005 0.0700 0.179000 0.0700 0.179005 0.1700 0.180000 0.1700 0.180005 0.0700 0.181000 0.0700 0.181005 0.1700 0.182000 0.1700 0.182005 0.0700 0.183000 0.0700 0.183005 0.1700 0.184000 0.1700 0.184005 0.0700 0.185000 0.0700 0.185005 0.1700 0.186000 0.1700 0.186005 0.0700 0.187000 0.0700 0.187005 0.1700 0.188000 0.1700 0.188005 0.0700 0.189000 0.0700 0.189005 0.1700 0.190000 0.1700 0.190005 0.0700 0.191000 0.0700 0.191005 0.1700 0.192000 0.1700 0.192005 0.0700 0.193000 0.0700 0.193005 0.1700 0.194000 0.1700 0.194005 0.0700 0.195000 0.0700 0.195005 0.1700 0.196000 0.1700 0.196005 0.0700 0.197000 0.0700 0.197005 0.1700 0.198000 0.1700 0.198005 0.0700 0.199000 0.0700 0.199005 0.1700 0.200000 0.1700 0.200005 0.0700 0.201000 0.0700 0.201005 0.1700 0.202000 0.1700 0.202005 0.0700 0.203000 0.0700 0.203005 0.1700 0.204000 0.1700 0.204005 0.0700 0.205000 0.0700 0.205005 0.1700 0.206000 0.1700 0.206005 0.0700 0.207000 0.0700 0.207005 0.1700 0.208000 0.1700 0.208005 0.0700 0.209000 0.0700 0.209005 0.1700 0.210000 0.1700 0.210005 0.0700 0.211000 0.0700 0.211005 0.1700 0.212000 0.1700 0.212005 0.0700 0.213000 0.0700 0.213005 0.1700 0.214000 0.1700 0.214005 0.0700 0.215000 0.0700 0.215005 0.1700 0.216000 0.1700 0.216005 0.0700 0.217000 0.0700 0.217005 0.1700 0.218000 0.1700 0.218005 0.0700 0.219000 0.0700 0.219005 0.1700 0.220000 0.1700 0.220005 0.0700 0.221000 0.0700 0.221005 0.1700 0.222000 0.1700 0.222005 0.0700 0.223000 0.0700 0.223005 0.1700 0.224000 0.1700 0.224005 0.0700 0.225000 0.0700 0.225005 0.1700 0.226000 0.1700 0.226005 0.0700 0.227000 0.0700 0.227005 0.1700 0.228000 0.1700 0.228005 0.0700 0.229000 0.0700 0.229005 0.1700 0.230000 0.1700 0.230005 0.0700 0.231000 0.0700 0.231005 0.1700 0.232000 0.1700 0.232005 0.0700 0.233000 0.0700 0.233005 0.1700 0.234000 0.1700 0.234005 0.0700 0.235000 0.0700 0.235005 0.1700 0.236000 0.1700 0.236005 0.0700 0.237000 0.0700 0.237005 0.1700 0.238000 0.1700 0.238005 0.0700 0.239000 0.0700 0.239005 0.1700 0.240000 0.1700 0.240005 0.0700 0.241000 0.0700 0.241005 0.1700 0.242000 0.1700 0.242005 0.0700 0.243000 0.0700 0.243005 0.1700 0.244000 0.1700 0.244005 0.0700 0.245000 0.0700 0.245005 0.1700 0.246000 0.1700 0.246005 0.0700 0.247000 0.0700 0.247005 0.1700 0.248000 0.1700 0.248005 0.0700 0.249000 0.0700 0.249005 0.1700 0.250000 0.1700 0.250005 0.0700 0.251000 0.0700 0.251005 0.1700 0.252000 0.1700 0.252005 0.0700 0.253000 0.0700 0.253005 0.1700 0.254000 0.1700 0.254005 0.0700 0.255000 0.0700 0.255005 0.1700 0.256000 0.1700 0.256005 0.0700 0.257000 0.0700 0.257005 0.1700 0.258000 0.1700 0.258005 0.0700 0.259000 0.0700 0.259005 0.1700 0.260000 0.1700 0.260005 0.0700 0.261000 0.0700 0.261005 0.1700 0.262000 0.1700 0.262005 0.0700 0.263000 0.0700 0.263005 0.1700 0.264000 0.1700 0.264005 0.0700 0.265000 0.0700 0.265005 0.1700 0.266000 0.1700 0.266005 0.0700 0.267000 0.0700 0.267005 0.1700 0.268000 0.1700 0.268005 0.0700 0.269000 0.0700 0.269005 0.1700 0.270000 0.1700 0.270005 0.0700 0.271000 0.0700 0.271005 0.1700 0.272000 0.1700 0.272005 0.0700 0.273000 0.0700 0.273005 0.1700 0.274000 0.1700 0.274005 0.0700 0.275000 0.0700 0.275005 0.1700 0.276000 0.1700 0.276005 0.0700 0.277000 0.0700 0.277005 0.1700 0.278000 0.1700 0.278005 0.0700 0.279000 0.0700 0.279005 0.1700 0.280000 0.1700 0.280005 0.0700 0.281000 0.0700 0.281005 0.1700 0.282000 0.1700 0.282005 0.0700 0.283000 0.0700 0.283005 0.1700 0.284000 0.1700 0.284005 0.0700 0.285000 0.0700 0.285005 0.1700 0.286000 0.1700 0.286005 0.0700 0.287000 0.0700 0.287005 0.1700 0.288000 0.1700 0.288005 0.0700 0.289000 0.0700 0.289005 0.1700 0.290000 0.1700 0.290005 0.0700 0.291000 0.0700 0.291005 0.1700 0.292000 0.1700 0.292005 0.0700 0.293000 0.0700 0.293005 0.1700 0.294000 0.1700 0.294005 0.0700 0.295000 0.0700 0.295005 0.1700 0.296000 0.1700 0.296005 0.0700 0.297000 0.0700 0.297005 0.1700 0.298000 0.1700 0.298005 0.0700 0.299000 0.0700 0.299005 0.1700 0.300000 0.1700 0.300005 0.0700 0.301000 0.0700 0.301005 0.1700 0.302000 0.1700 0.302005 0.0700 0.303000 0.0700 0.303005 0.1700 0.304000 0.1700 0.304005 0.0700 0.305000 0.0700 0.305005 0.1700 0.306000 0.1700 0.306005 0.0700 0.307000 0.0700 0.307005 0.1700 0.308000 0.1700 0.308005 0.0700 0.309000 0.0700 0.309005 0.1700 0.310000 0.1700 0.310005 0.0700 0.311000 0.0700 0.311005 0.1700 0.312000 0.1700 0.312005 0.0700 0.313000 0.0700 0.313005 0.1700 0.314000 0.1700 0.314005 0.0700 0.315000 0.0700 0.315005 0.1700 0.316000 0.1700 0.316005 0.0700 0.317000 0.0700 0.317005 0.1700 0.318000 0.1700 0.318005 0.0700 0.319000 0.0700 0.319005 0.1700 0.320000 0.1700 0.320005 0.0700 0.325000 0.0700 0.325005 0.1700 0.327000 0.1700 0.327005 0.0700 0.329000 0.0700 0.329005 0.1700 0.331000 0.1700 0.331005 0.0700 0.333000 0.0700 0.333005 0.1700 0.335000 0.1700 0.335005 0.0700 0.337000 0.0700 0.337005 0.1700 0.339000 0.1700 0.339005 0.0700 0.341000 0.0700 0.341005 0.1700 0.343000 0.1700 0.343005 0.0700 0.345000 0.0700 0.345005 0.1700 0.347000 0.1700 0.347005 0.0700 0.349000 0.0700 0.349005 0.1700 0.351000 0.1700 0.351005 0.0700 0.353000 0.0700 0.353005 0.1700 0.355000 0.1700 0.355005 0.0700 0.357000 0.0700 0.357005 0.1700 0.359000 0.1700 0.359005 0.0700 0.361000 0.0700 0.361005 0.1700 0.363000 0.1700 0.363005 0.0700 0.365000 0.0700 0.365005 0.1700 0.367000 0.1700 0.367005 0.0700 0.369000 0.0700 0.369005 0.1700 0.371000 0.1700 0.371005 0.0700 0.373000 0.0700 0.373005 0.1700 0.375000 0.1700 0.375005 0.0700 0.377000 0.0700 0.377005 0.1700 0.379000 0.1700 0.379005 0.0700 0.381000 0.0700 0.381005 0.1700 0.383000 0.1700 0.383005 0.0700 0.385000 0.0700 0.385005 0.1700 0.387000 0.1700 0.387005 0.0700 0.389000 0.0700 0.389005 0.1700 0.391000 0.1700 0.391005 0.0700 0.393000 0.0700 0.393005 0.1700 0.395000 0.1700 0.395005 0.0700 0.397000 0.0700 0.397005 0.1700 0.399000 0.1700 0.399005 0.0700 0.401000 0.0700 0.401005 0.1700 0.403000 0.1700 0.403005 0.0700 0.405000 0.0700 0.405005 0.1700 0.407000 0.1700 0.407005 0.0700 0.409000 0.0700 0.409005 0.1700 0.411000 0.1700 0.411005 0.0700 0.413000 0.0700 0.413005 0.1700 0.415000 0.1700 0.415005 0.0700 0.417000 0.0700 0.417005 0.1700 0.419000 0.1700 0.419005 0.0700 0.421000 0.0700 0.421005 0.1700 0.423000 0.1700 0.423005 0.0700 0.425000 0.0700 0.425005 0.1700 0.427000 0.1700 0.427005 0.0700 0.429000 0.0700 0.429005 0.1700 0.431000 0.1700 0.431005 0.0700 0.433000 0.0700 0.433005 0.1700 0.435000 0.1700 0.435005 0.0700 0.437000 0.0700 0.437005 0.1700 0.439000 0.1700 0.439005 0.0700 0.441000 0.0700 0.441005 0.1700 0.443000 0.1700 0.443005 0.0700 0.445000 0.0700 0.445005 0.1700 0.447000 0.1700 0.447005 0.0700 0.449000 0.0700 0.449005 0.1700 0.451000 0.1700 0.451005 0.0700 0.453000 0.0700 0.453005 0.1700 0.455000 0.1700 0.455005 0.0700 0.457000 0.0700 0.457005 0.1700 0.459000 0.1700 0.459005 0.0700 0.461000 0.0700 0.461005 0.1700 0.463000 0.1700 0.463005 0.0700 0.465000 0.0700 0.465005 0.1700 0.467000 0.1700 0.467005 0.0700 0.469000 0.0700 0.469005 0.1700 0.471000 0.1700 0.471005 0.0700 0.473000 0.0700 0.473005 0.1700 0.475000 0.1700 0.475005 0.0700 0.477000 0.0700 0.477005 0.1700 0.479000 0.1700 0.479005 0.0700 0.481000 0.0700 0.481005 0.1700 0.483000 0.1700 0.483005 0.0700 0.485000 0.0700 0.485005 0.1700 0.487000 0.1700 0.487005 0.0700 0.489000 0.0700 0.489005 0.1700 0.491000 0.1700 0.491005 0.0700 0.493000 0.0700 0.493005 0.1700 0.495000 0.1700 0.495005 0.0700 0.497000 0.0700 0.497005 0.1700 0.499000 0.1700 0.499005 0.0700 0.501000 0.0700 0.501005 0.1700 0.503000 0.1700 0.503005 0.0700 0.505000 0.0700 0.505005 0.1700 0.507000 0.1700 0.507005 0.0700 0.509000 0.0700 0.509005 0.1700 0.511000 0.1700 0.511005 0.0700 0.513000 0.0700 0.513005 0.1700 0.515000 0.1700 0.515005 0.0700 0.517000 0.0700 0.517005 0.1700 0.519000 0.1700 0.519005 0.0700 0.521000 0.0700 0.521005 0.1700 0.523000 0.1700 0.523005 0.0700 0.525000 0.0700 0.525005 0.1700 0.527000 0.1700 0.527005 0.0700 0.529000 0.0700 0.529005 0.1700 0.531000 0.1700 0.531005 0.0700 0.533000 0.0700 0.533005 0.1700 0.535000 0.1700 0.535005 0.0700 0.537000 0.0700 0.537005 0.1700 0.539000 0.1700 0.539005 0.0700 0.541000 0.0700 0.541005 0.1700 0.543000 0.1700 0.543005 0.0700 0.545000 0.0700 0.545005 0.1700 0.547000 0.1700 0.547005 0.0700 0.549000 0.0700 0.549005 0.1700 0.551000 0.1700 0.551005 0.0700 0.553000 0.0700 0.553005 0.1700 0.555000 0.1700 0.555005 0.0700 0.557000 0.0700 0.557005 0.1700 0.559000 0.1700 0.559005 0.0700 0.561000 0.0700 0.561005 0.1700 0.563000 0.1700 0.563005 0.0700 0.565000 0.0700 0.565005 0.1700 0.567000 0.1700 0.567005 0.0700 0.569000 0.0700 0.569005 0.1700 0.571000 0.1700 0.571005 0.0700 0.573000 0.0700 0.573005 0.1700 0.575000 0.1700 0.575005 0.0700 0.577000 0.0700 0.577005 0.1700 0.579000 0.1700 0.579005 0.0700 0.581000 0.0700 0.581005 0.1700 0.583000 0.1700 0.583005 0.0700 0.585000 0.0700 0.585005 0.1700 0.587000 0.1700 0.587005 0.0700 0.589000 0.0700 0.589005 0.1700 0.591000 0.1700 0.591005 0.0700 0.593000 0.0700 0.593005 0.1700 0.595000 0.1700 0.595005 0.0700 0.597000 0.0700 0.597005 0.1700 0.599000 0.1700 0.599005 0.0700 0.601000 0.0700 0.601005 0.1700 0.603000 0.1700 0.603005 0.0700 0.605000 0.0700 0.605005 0.1700 0.607000 0.1700 0.607005 0.0700 0.609000 0.0700 0.609005 0.1700 0.611000 0.1700 0.611005 0.0700 0.613000 0.0700 0.613005 0.1700 0.615000 0.1700 0.615005 0.0700 0.617000 0.0700 0.617005 0.1700 0.619000 0.1700 0.619005 0.0700 0.621000 0.0700 0.621005 0.1700 0.623000 0.1700 0.623005 0.0700 0.625000 0.0700 0.625005 0.1700 0.627000 0.1700 0.627005 0.0700 0.629000 0.0700 0.629005 0.1700 0.631000 0.1700 0.631005 0.0700 0.633000 0.0700 0.633005 0.1700 0.635000 0.1700 0.635005 0.0700 0.637000 0.0700 0.637005 0.1700 0.639000 0.1700 0.639005 0.0700 0.641000 0.0700 0.641005 0.1700 0.643000 0.1700 0.643005 0.0700 0.645000 0.0700 0.645005 0.1700 0.647000 0.1700 0.647005 0.0700 0.649000 0.0700 0.649005 0.1700 0.651000 0.1700 0.651005 0.0700 0.653000 0.0700 0.653005 0.1700 0.655000 0.1700 0.655005 0.0700 0.657000 0.0700 0.657005 0.1700 0.659000 0.1700 0.659005 0.0700 0.661000 0.0700 0.661005 0.1700 0.663000 0.1700 0.663005 0.0700 0.665000 0.0700 0.665005 0.1700 0.667000 0.1700 0.667005 0.0700 0.669000 0.0700 0.669005 0.1700 0.671000 0.1700 0.671005 0.0700 0.673000 0.0700 0.673005 0.1700 0.675000 0.1700 0.675005 0.0700 0.677000 0.0700 0.677005 0.1700 0.679000 0.1700 0.679005 0.0700 0.681000 0.0700 0.681005 0.1700 0.683000 0.1700 0.683005 0.0700 0.685000 0.0700 0.685005 0.1700 0.687000 0.1700 0.687005 0.0700 0.689000 0.0700 0.689005 0.1700 0.691000 0.1700 0.691005 0.0700 0.693000 0.0700 0.693005 0.1700 0.695000 0.1700 0.695005 0.0700 0.697000 0.0700 0.697005 0.1700 0.699000 0.1700 0.699005 0.0700 0.701000 0.0700 0.701005 0.1700 0.703000 0.1700 0.703005 0.0700 0.705000 0.0700 0.705005 0.1700 0.707000 0.1700 0.707005 0.0700 0.709000 0.0700 0.709005 0.1700 0.711000 0.1700 0.711005 0.0700 0.713000 0.0700 0.713005 0.1700 0.715000 0.1700 0.715005 0.0700 0.717000 0.0700 0.717005 0.1700 0.719000 0.1700 0.719005 0.0700 0.721000 0.0700 0.721005 0.1700 0.723000 0.1700 0.723005 0.0700 0.725000 0.0700 0.725005 0.1700 0.727000 0.1700 0.727005 0.0700 0.729000 0.0700 0.729005 0.1700 0.731000 0.1700 0.731005 0.0700 0.733000 0.0700 0.733005 0.1700 0.735000 0.1700 0.735005 0.0700 0.737000 0.0700 0.737005 0.1700 0.739000 0.1700 0.739005 0.0700 0.741000 0.0700 0.741005 0.1700 0.743000 0.1700 0.743005 0.0700 0.745000 0.0700 0.745005 0.1700 0.747000 0.1700 0.747005 0.0700 0.749000 0.0700 0.749005 0.1700 0.751000 0.1700 0.751005 0.0700 0.753000 0.0700 0.753005 0.1700 0.755000 0.1700 0.755005 0.0700 0.757000 0.0700 0.757005 0.1700 0.759000 0.1700 0.759005 0.0700 0.761000 0.0700 0.761005 0.1700 0.763000 0.1700 0.763005 0.0700 0.765000 0.0700 0.765005 0.1700 0.767000 0.1700 0.767005 0.0700 0.769000 0.0700 0.769005 0.1700 0.771000 0.1700 0.771005 0.0700 0.773000 0.0700 0.773005 0.1700 0.775000 0.1700 0.775005 0.0700 0.777000 0.0700 0.777005 0.1700 0.779000 0.1700 0.779005 0.0700 0.781000 0.0700 0.781005 0.1700 0.783000 0.1700 0.783005 0.0700 0.785000 0.0700 0.785005 0.1700 0.787000 0.1700 0.787005 0.0700 0.789000 0.0700 0.789005 0.1700 0.791000 0.1700 0.791005 0.0700 0.793000 0.0700 0.793005 0.1700 0.795000 0.1700 0.795005 0.0700 0.797000 0.0700 0.797005 0.1700 0.799000 0.1700 0.799005 0.0700 0.801000 0.0700 0.801005 0.1700 0.803000 0.1700 0.803005 0.0700 0.805000 0.0700 0.805005 0.1700 0.807000 0.1700 0.807005 0.0700 0.809000 0.0700 0.809005 0.1700 0.811000 0.1700 0.811005 0.0700 0.813000 0.0700 0.813005 0.1700 0.815000 0.1700 0.815005 0.0700 0.817000 0.0700 0.817005 0.1700 0.819000 0.1700 0.819005 0.0700 0.821000 0.0700 0.821005 0.1700 0.823000 0.1700 0.823005 0.0700 0.825000 0.0700 0.825005 0.1700 0.827000 0.1700 0.827005 0.0700 0.829000 0.0700 0.829005 0.1700 0.831000 0.1700 0.831005 0.0700 0.833000 0.0700 0.833005 0.1700 0.835000 0.1700 0.835005 0.0700 0.837000 0.0700 0.837005 0.1700 0.839000 0.1700 0.839005 0.0700 0.841000 0.0700 0.841005 0.1700 0.843000 0.1700 0.843005 0.0700 0.845000 0.0700 0.845005 0.1700 0.847000 0.1700 0.847005 0.0700 0.849000 0.0700 0.849005 0.1700 0.851000 0.1700 0.851005 0.0700 0.853000 0.0700 0.853005 0.1700 0.855000 0.1700 0.855005 0.0700 0.857000 0.0700 0.857005 0.1700 0.859000 0.1700 0.859005 0.0700 0.861000 0.0700 0.861005 0.1700 0.863000 0.1700 0.863005 0.0700 0.865000 0.0700 0.865005 0.1700 0.867000 0.1700 0.867005 0.0700 0.869000 0.0700 0.869005 0.1700 0.871000 0.1700 0.871005 0.0700 0.873000 0.0700 0.873005 0.1700 0.875000 0.1700 0.875005 0.0700 0.877000 0.0700 0.877005 0.1700 0.879000 0.1700 0.879005 0.0700 0.881000 0.0700 0.881005 0.1700 0.883000 0.1700 0.883005 0.0700 0.885000 0.0700 0.885005 0.1700 0.887000 0.1700 0.887005 0.0700 0.889000 0.0700 0.889005 0.1700 0.891000 0.1700 0.891005 0.0700 0.893000 0.0700 0.893005 0.1700 0.895000 0.1700 0.895005 0.0700 0.897000 0.0700 0.897005 0.1700 0.899000 0.1700 0.899005 0.0700 0.901000 0.0700 0.901005 0.1700 0.903000 0.1700 0.903005 0.0700 0.905000 0.0700 0.905005 0.1700 0.907000 0.1700 0.907005 0.0700 0.909000 0.0700 0.909005 0.1700 0.911000 0.1700 0.911005 0.0700 0.913000 0.0700 0.913005 0.1700 0.915000 0.1700 0.915005 0.0700 0.917000 0.0700 0.917005 0.1700 0.919000 0.1700 0.919005 0.0700 0.921000 0.0700 0.921005 0.1700 0.923000 0.1700 0.923005 0.0700 0.925000 0.0700 0.925005 0.1700 0.927000 0.1700 0.927005 0.0700 0.929000 0.0700 0.929005 0.1700 0.931000 0.1700 0.931005 0.0700 0.933000 0.0700 0.933005 0.1700 0.935000 0.1700 0.935005 0.0700 0.937000 0.0700 0.937005 0.1700 0.939000 0.1700 0.939005 0.0700 0.941000 0.0700 0.941005 0.1700 0.943000 0.1700 0.943005 0.0700 0.945000 0.0700 0.945005 0.1700 0.947000 0.1700 0.947005 0.0700 0.949000 0.0700 0.949005 0.1700 0.951000 0.1700 0.951005 0.0700 0.953000 0.0700 0.953005 0.1700 0.955000 0.1700 0.955005 0.0700 0.957000 0.0700 0.957005 0.1700 0.959000 0.1700 0.959005 0.0700 0.961000 0.0700 0.961005 0.1700 0.963000 0.1700 0.963005 0.0700 0.965000 0.0700 0.965005 0.1700 0.967000 0.1700 0.967005 0.0700 0.969000 0.0700 0.969005 0.1700 0.971000 0.1700 0.971005 0.0700 0.973000 0.0700 0.973005 0.1700 0.975000 0.1700 0.975005 0.0700 0.977000 0.0700 0.977005 0.1700 0.979000 0.1700 0.979005 0.0700 0.981000 0.0700 0.981005 0.1700 0.983000 0.1700 0.983005 0.0700 0.985000 0.0700 0.985005 0.1700 0.987000 0.1700 0.987005 0.0700 0.989000 0.0700 0.989005 0.1700 0.991000 0.1700 0.991005 0.0700 0.993000 0.0700 0.993005 0.1700 0.995000 0.1700 0.995005 0.0700 0.997000 0.0700 0.997005 0.1700 0.999000 0.1700 0.999005 0.0700 1.001000 0.0700 1.001005 0.1700 1.003000 0.1700 1.003005 0.0700 1.005000 0.0700 1.005005 0.1700 1.007000 0.1700 1.007005 0.0700 1.009000 0.0700 1.009005 0.1700 1.011000 0.1700 1.011005 0.0700 1.013000 0.0700 1.013005 0.1700 1.015000 0.1700 1.015005 0.0700 1.017000 0.0700 1.017005 0.1700 1.019000 0.1700 1.019005 0.0700 1.021000 0.0700 1.021005 0.1700 1.023000 0.1700 1.023005 0.0700 1.025000 0.0700 1.025005 0.1700 1.027000 0.1700 1.027005 0.0700 1.029000 0.0700 1.029005 0.1700 1.031000 0.1700 1.031005 0.0700 1.033000 0.0700 1.033005 0.1700 1.035000 0.1700 1.035005 0.0700 1.037000 0.0700 1.037005 0.1700 1.039000 0.1700 1.039005 0.0700 1.041000 0.0700 1.041005 0.1700 1.043000 0.1700 1.043005 0.0700 1.045000 0.0700 1.045005 0.1700 1.047000 0.1700 1.047005 0.0700 1.049000 0.0700 1.049005 0.1700 1.051000 0.1700 1.051005 0.0700 1.053000 0.0700 1.053005 0.1700 1.055000 0.1700 1.055005 0.0700 1.057000 0.0700 1.057005 0.1700 1.059000 0.1700 1.059005 0.0700 1.061000 0.0700 1.061005 0.1700 1.063000 0.1700 1.063005 0.0700 1.065000 0.0700 1.065005 0.1700 1.067000 0.1700 1.067005 0.0700 1.069000 0.0700 1.069005 0.1700 1.071000 0.1700 1.071005 0.0700 1.073000 0.0700 1.073005 0.1700 1.075000 0.1700 1.075005 0.0700 1.077000 0.0700 1.077005 0.1700 1.079000 0.1700 1.079005 0.0700 1.081000 0.0700 1.081005 0.1700 1.083000 0.1700 1.083005 0.0700 1.085000 0.0700 1.085005 0.1700 1.087000 0.1700 1.087005 0.0700 1.089000 0.0700 1.089005 0.1700 1.091000 0.1700 1.091005 0.0700 1.093000 0.0700 1.093005 0.1700 1.095000 0.1700 1.095005 0.0700 1.097000 0.0700 1.097005 0.1700 1.099000 0.1700 1.099005 0.0700 1.101000 0.0700 1.101005 0.1700 1.103000 0.1700 1.103005 0.0700 1.105000 0.0700 1.105005 0.1700 1.107000 0.1700 1.107005 0.0700 1.109000 0.0700 1.109005 0.1700 1.111000 0.1700 1.111005 0.0700 1.113000 0.0700 1.113005 0.1700 1.115000 0.1700 1.115005 0.0700 1.117000 0.0700 1.117005 0.1700 1.119000 0.1700 1.119005 0.0700 1.121000 0.0700 1.121005 0.1700 1.123000 0.1700 1.123005 0.0700 1.125000 0.0700 1.125005 0.1700 1.127000 0.1700 1.127005 0.0700 1.129000 0.0700 1.129005 0.1700 1.131000 0.1700 1.131005 0.0700 1.133000 0.0700 1.133005 0.1700 1.135000 0.1700 1.135005 0.0700 1.137000 0.0700 1.137005 0.1700 1.139000 0.1700 1.139005 0.0700 1.141000 0.0700 1.141005 0.1700 1.143000 0.1700 1.143005 0.0700 1.145000 0.0700 1.145005 0.1700 1.147000 0.1700 1.147005 0.0700 1.149000 0.0700 1.149005 0.1700 1.151000 0.1700 1.151005 0.0700 1.153000 0.0700 1.153005 0.1700 1.155000 0.1700 1.155005 0.0700 1.157000 0.0700 1.157005 0.1700 1.159000 0.1700 1.159005 0.0700 1.161000 0.0700 1.161005 0.1700 1.163000 0.1700 1.163005 0.0700 1.165000 0.0700 1.165005 0.1700 1.167000 0.1700 1.167005 0.0700 1.169000 0.0700 1.169005 0.1700 1.171000 0.1700 1.171005 0.0700 1.173000 0.0700 1.173005 0.1700 1.175000 0.1700 1.175005 0.0700 1.177000 0.0700 1.177005 0.1700 1.179000 0.1700 1.179005 0.0700 1.181000 0.0700 1.181005 0.1700 1.183000 0.1700 1.183005 0.0700 1.185000 0.0700 1.185005 0.1700 1.187000 0.1700 1.187005 0.0700 1.189000 0.0700 1.189005 0.1700 1.191000 0.1700 1.191005 0.0700 1.193000 0.0700 1.193005 0.1700 1.195000 0.1700 1.195005 0.0700 1.197000 0.0700 1.197005 0.1700 1.199000 0.1700 1.199005 0.0700 1.201000 0.0700 1.201005 0.1700 1.203000 0.1700 1.203005 0.0700 1.205000 0.0700 1.205005 0.1700 1.207000 0.1700 1.207005 0.0700 1.209000 0.0700 1.209005 0.1700 1.211000 0.1700 1.211005 0.0700 1.213000 0.0700 1.213005 0.1700 1.215000 0.1700 1.215005 0.0700 1.217000 0.0700 1.217005 0.1700 1.219000 0.1700 1.219005 0.0700 1.221000 0.0700 1.221005 0.1700 1.223000 0.1700 1.223005 0.0700 1.225000 0.0700 1.225005 0.1700 1.227000 0.1700 1.227005 0.0700 1.229000 0.0700 1.229005 0.1700 1.231000 0.1700 1.231005 0.0700 1.233000 0.0700 1.233005 0.1700 1.235000 0.1700 1.235005 0.0700 1.237000 0.0700 1.237005 0.1700 1.239000 0.1700 1.239005 0.0700 1.241000 0.0700 1.241005 0.1700 1.243000 0.1700 1.243005 0.0700 1.245000 0.0700 1.245005 0.1700 1.247000 0.1700 1.247005 0.0700 1.249000 0.0700 1.249005 0.1700 1.251000 0.1700 1.251005 0.0700 1.253000 0.0700 1.253005 0.1700 1.255000 0.1700 1.255005 0.0700 1.257000 0.0700 1.257005 0.1700 1.259000 0.1700 1.259005 0.0700 1.261000 0.0700 1.261005 0.1700 1.263000 0.1700 1.263005 0.0700 1.265000 0.0700 1.265005 0.1700 1.267000 0.1700 1.267005 0.0700 1.269000 0.0700 1.269005 0.1700 1.271000 0.1700 1.271005 0.0700 1.273000 0.0700 1.273005 0.1700 1.275000 0.1700 1.275005 0.0700 1.277000 0.0700 1.277005 0.1700 1.279000 0.1700 1.279005 0.0700 1.281000 0.0700 1.281005 0.1700 1.283000 0.1700 1.283005 0.0700 1.285000 0.0700 1.285005 0.1700 1.287000 0.1700 1.287005 0.0700 1.289000 0.0700 1.289005 0.1700 1.291000 0.1700 1.291005 0.0700 1.293000 0.0700 1.293005 0.1700 1.295000 0.1700 1.295005 0.0700 1.297000 0.0700 1.297005 0.1700 1.299000 0.1700 1.299005 0.0700 1.301000 0.0700 1.301005 0.1700 1.303000 0.1700 1.303005 0.0700 1.305000 0.0700 1.305005 0.1700 1.307000 0.1700 1.307005 0.0700 1.309000 0.0700 1.309005 0.1700 1.311000 0.1700 1.311005 0.0700 1.313000 0.0700 1.313005 0.1700 1.315000 0.1700 1.315005 0.0700 1.317000 0.0700 1.317005 0.1700 1.319000 0.1700 1.319005 0.0700 1.321000 0.0700 1.321005 0.1700 1.323000 0.1700 1.323005 0.0700 1.325000 0.0700 1.325005 0.1700 1.327000 0.1700 1.327005 0.0700 1.329000 0.0700 1.329005 0.1700 1.331000 0.1700 1.331005 0.0700 1.333000 0.0700 1.333005 0.1700 1.335000 0.1700 1.335005 0.0700 1.337000 0.0700 1.337005 0.1700 1.339000 0.1700 1.339005 0.0700 1.341000 0.0700 1.341005 0.1700 1.343000 0.1700 1.343005 0.0700 1.345000 0.0700 1.345005 0.1700 1.347000 0.1700 1.347005 0.0700 1.349000 0.0700 1.349005 0.1700 1.351000 0.1700 1.351005 0.0700 1.353000 0.0700 1.353005 0.1700 1.355000 0.1700 1.355005 0.0700 1.357000 0.0700 1.357005 0.1700 1.359000 0.1700 1.359005 0.0700 1.361000 0.0700 1.361005 0.1700 1.363000 0.1700 1.363005 0.0700 1.365000 0.0700 1.365005 0.1700 1.367000 0.1700 1.367005 0.0700 1.369000 0.0700 1.369005 0.1700 1.371000 0.1700 1.371005 0.0700 1.373000 0.0700 1.373005 0.1700 1.375000 0.1700 1.375005 0.0700 1.377000 0.0700 1.377005 0.1700 1.379000 0.1700 1.379005 0.0700 1.381000 0.0700 1.381005 0.1700 1.383000 0.1700 1.383005 0.0700 1.385000 0.0700 1.385005 0.1700 1.387000 0.1700 1.387005 0.0700 1.389000 0.0700 1.389005 0.1700 1.391000 0.1700 1.391005 0.0700 1.393000 0.0700 1.393005 0.1700 1.395000 0.1700 1.395005 0.0700 1.397000 0.0700 1.397005 0.1700 1.399000 0.1700 1.399005 0.0700 1.401000 0.0700 1.401005 0.1700 1.403000 0.1700 1.403005 0.0700 1.405000 0.0700 1.405005 0.1700 1.407000 0.1700 1.407005 0.0700 1.409000 0.0700 1.409005 0.1700 1.411000 0.1700 1.411005 0.0700 1.413000 0.0700 1.413005 0.1700 1.415000 0.1700 1.415005 0.0700 1.417000 0.0700 1.417005 0.1700 1.419000 0.1700 1.419005 0.0700 1.421000 0.0700 1.421005 0.1700 1.423000 0.1700 1.423005 0.0700 1.425000 0.0700 1.425005 0.1700 1.427000 0.1700 1.427005 0.0700 1.429000 0.0700 1.429005 0.1700 1.431000 0.1700 1.431005 0.0700 1.433000 0.0700 1.433005 0.1700 1.435000 0.1700 1.435005 0.0700 1.437000 0.0700 1.437005 0.1700 1.439000 0.1700 1.439005 0.0700 1.441000 0.0700 1.441005 0.1700 1.443000 0.1700 1.443005 0.0700 1.445000 0.0700 1.445005 0.1700 1.447000 0.1700 1.447005 0.0700 1.449000 0.0700 1.449005 0.1700 1.451000 0.1700 1.451005 0.0700 1.453000 0.0700 1.453005 0.1700 1.455000 0.1700 1.455005 0.0700 1.457000 0.0700 1.457005 0.1700 1.459000 0.1700 1.459005 0.0700 1.461000 0.0700 1.461005 0.1700 1.463000 0.1700 1.463005 0.0700 1.465000 0.0700 1.465005 0.1700 1.467000 0.1700 1.467005 0.0700 1.469000 0.0700 1.469005 0.1700 1.471000 0.1700 1.471005 0.0700 1.473000 0.0700 1.473005 0.1700 1.475000 0.1700 1.475005 0.0700 1.477000 0.0700 1.477005 0.1700 1.479000 0.1700 1.479005 0.0700 1.481000 0.0700 1.481005 0.1700 1.483000 0.1700 1.483005 0.0700 1.485000 0.0700 1.485005 0.1700 1.487000 0.1700 1.487005 0.0700 1.489000 0.0700 1.489005 0.1700 1.491000 0.1700 1.491005 0.0700 1.493000 0.0700 1.493005 0.1700 1.495000 0.1700 1.495005 0.0700 1.497000 0.0700 1.497005 0.1700 1.499000 0.1700 1.499005 0.0700 1.501000 0.0700 1.501005 0.1700 1.503000 0.1700 1.503005 0.0700 1.505000 0.0700 1.505005 0.1700 1.507000 0.1700 1.507005 0.0700 1.509000 0.0700 1.509005 0.1700 1.511000 0.1700 1.511005 0.0700 1.513000 0.0700 1.513005 0.1700 1.515000 0.1700 1.515005 0.0700 1.517000 0.0700 1.517005 0.1700 1.519000 0.1700 1.519005 0.0700 1.521000 0.0700 1.521005 0.1700 1.523000 0.1700 1.523005 0.0700 1.525000 0.0700 1.525005 0.1700 1.527000 0.1700 1.527005 0.0700 1.529000 0.0700 1.529005 0.1700 1.531000 0.1700 1.531005 0.0700 1.533000 0.0700 1.533005 0.1700 1.535000 0.1700 1.535005 0.0700 1.537000 0.0700 1.537005 0.1700 1.539000 0.1700 1.539005 0.0700 1.541000 0.0700 1.541005 0.1700 1.543000 0.1700 1.543005 0.0700 1.545000 0.0700 1.545005 0.1700 1.547000 0.1700 1.547005 0.0700 1.549000 0.0700 1.549005 0.1700 1.551000 0.1700 1.551005 0.0700 1.553000 0.0700 1.553005 0.1700 1.555000 0.1700 1.555005 0.0700 1.557000 0.0700 1.557005 0.1700 1.559000 0.1700 1.559005 0.0700 1.561000 0.0700 1.561005 0.1700 1.563000 0.1700 1.563005 0.0700 1.565000 0.0700 1.565005 0.1700 1.567000 0.1700 1.567005 0.0700 1.569000 0.0700 1.569005 0.1700 1.571000 0.1700 1.571005 0.0700 1.573000 0.0700 1.573005 0.1700 1.575000 0.1700 1.575005 0.0700 1.577000 0.0700 1.577005 0.1700 1.579000 0.1700 1.579005 0.0700 1.581000 0.0700 1.581005 0.1700 1.583000 0.1700 1.583005 0.0700 1.585000 0.0700 1.585005 0.1700 1.587000 0.1700 1.587005 0.0700 1.589000 0.0700 1.589005 0.1700 1.591000 0.1700 1.591005 0.0700 1.593000 0.0700 1.593005 0.1700 1.595000 0.1700 1.595005 0.0700 1.597000 0.0700 1.597005 0.1700 1.599000 0.1700 1.599005 0.0700 1.601000 0.0700 1.601005 0.1700 1.603000 0.1700 1.603005 0.0700 1.605000 0.0700 1.605005 0.1700 1.607000 0.1700 1.607005 0.0700 1.609000 0.0700 1.609005 0.1700 1.611000 0.1700 1.611005 0.0700 1.613000 0.0700 1.613005 0.1700 1.615000 0.1700 1.615005 0.0700 1.617000 0.0700 1.617005 0.1700 1.619000 0.1700 1.619005 0.0700 1.621000 0.0700 1.621005 0.1700 1.623000 0.1700 1.623005 0.0700 1.625000 0.0700 1.625005 0.1700 1.627000 0.1700 1.627005 0.0700 1.629000 0.0700 1.629005 0.1700 1.631000 0.1700 1.631005 0.0700 1.633000 0.0700 1.633005 0.1700 1.635000 0.1700 1.635005 0.0700 1.637000 0.0700 1.637005 0.1700 1.639000 0.1700 1.639005 0.0700 1.641000 0.0700 1.641005 0.1700 1.643000 0.1700 1.643005 0.0700 1.645000 0.0700 1.645005 0.1700 1.647000 0.1700 1.647005 0.0700 1.649000 0.0700 1.649005 0.1700 1.651000 0.1700 1.651005 0.0700 1.653000 0.0700 1.653005 0.1700 1.655000 0.1700 1.655005 0.0700 1.657000 0.0700 1.657005 0.1700 1.659000 0.1700 1.659005 0.0700 1.661000 0.0700 1.661005 0.1700 1.663000 0.1700 1.663005 0.0700 1.665000 0.0700 1.665005 0.1700 1.667000 0.1700 1.667005 0.0700 1.669000 0.0700 1.669005 0.1700 1.671000 0.1700 1.671005 0.0700 1.673000 0.0700 1.673005 0.1700 1.675000 0.1700 1.675005 0.0700 1.677000 0.0700 1.677005 0.1700 1.679000 0.1700 1.679005 0.0700 1.681000 0.0700 1.681005 0.1700 1.683000 0.1700 1.683005 0.0700 1.685000 0.0700 1.685005 0.1700 1.687000 0.1700 1.687005 0.0700 1.689000 0.0700 1.689005 0.1700 1.691000 0.1700 1.691005 0.0700 1.693000 0.0700 1.693005 0.1700 1.695000 0.1700 1.695005 0.0700 1.697000 0.0700 1.697005 0.1700 1.699000 0.1700 1.699005 0.0700 1.701000 0.0700 1.701005 0.1700 1.703000 0.1700 1.703005 0.0700 1.705000 0.0700 1.705005 0.1700 1.707000 0.1700 1.707005 0.0700 1.709000 0.0700 1.709005 0.1700 1.711000 0.1700 1.711005 0.0700 1.713000 0.0700 1.713005 0.1700 1.715000 0.1700 1.715005 0.0700 1.717000 0.0700 1.717005 0.1700 1.719000 0.1700 1.719005 0.0700 1.721000 0.0700 1.721005 0.1700 1.723000 0.1700 1.723005 0.0700 1.725000 0.0700 1.725005 0.1700 1.727000 0.1700 1.727005 0.0700 1.729000 0.0700 1.729005 0.1700 1.731000 0.1700 1.731005 0.0700 1.733000 0.0700 1.733005 0.1700 1.735000 0.1700 1.735005 0.0700 1.737000 0.0700 1.737005 0.1700 1.739000 0.1700 1.739005 0.0700 1.741000 0.0700 1.741005 0.1700 1.743000 0.1700 1.743005 0.0700 1.745000 0.0700 1.745005 0.1700 1.747000 0.1700 1.747005 0.0700 1.749000 0.0700 1.749005 0.1700 1.751000 0.1700 1.751005 0.0700 1.753000 0.0700 1.753005 0.1700 1.755000 0.1700 1.755005 0.0700 1.757000 0.0700 1.757005 0.1700 1.759000 0.1700 1.759005 0.0700 1.761000 0.0700 1.761005 0.1700 1.763000 0.1700 1.763005 0.0700 1.765000 0.0700 1.765005 0.1700 1.767000 0.1700 1.767005 0.0700 1.769000 0.0700 1.769005 0.1700 1.771000 0.1700 1.771005 0.0700 1.773000 0.0700 1.773005 0.1700 1.775000 0.1700 1.775005 0.0700 1.777000 0.0700 1.777005 0.1700 1.779000 0.1700 1.779005 0.0700 1.781000 0.0700 1.781005 0.1700 1.783000 0.1700 1.783005 0.0700 1.785000 0.0700 1.785005 0.1700 1.787000 0.1700 1.787005 0.0700 1.789000 0.0700 1.789005 0.1700 1.791000 0.1700 1.791005 0.0700 1.793000 0.0700 1.793005 0.1700 1.795000 0.1700 1.795005 0.0700 1.797000 0.0700 1.797005 0.1700 1.799000 0.1700 1.799005 0.0700 1.801000 0.0700 1.801005 0.1700 1.803000 0.1700 1.803005 0.0700 1.805000 0.0700 1.805005 0.1700 1.807000 0.1700 1.807005 0.0700 1.809000 0.0700 1.809005 0.1700 1.811000 0.1700 1.811005 0.0700 1.813000 0.0700 1.813005 0.1700 1.815000 0.1700 1.815005 0.0700 1.817000 0.0700 1.817005 0.1700 1.819000 0.1700 1.819005 0.0700 1.821000 0.0700 1.821005 0.1700 1.823000 0.1700 1.823005 0.0700 1.825000 0.0700 1.825005 0.1700 1.827000 0.1700 1.827005 0.0700 1.829000 0.0700 1.829005 0.1700 1.831000 0.1700 1.831005 0.0700 1.833000 0.0700 1.833005 0.1700 1.835000 0.1700 1.835005 0.0700 1.837000 0.0700 1.837005 0.1700 1.839000 0.1700 1.839005 0.0700 1.841000 0.0700 1.841005 0.1700 1.843000 0.1700 1.843005 0.0700 1.845000 0.0700 1.845005 0.1700 1.847000 0.1700 1.847005 0.0700 1.849000 0.0700 1.849005 0.1700 1.851000 0.1700 1.851005 0.0700 1.853000 0.0700 1.853005 0.1700 1.855000 0.1700 1.855005 0.0700 1.857000 0.0700 1.857005 0.1700 1.859000 0.1700 1.859005 0.0700 1.861000 0.0700 1.861005 0.1700 1.863000 0.1700 1.863005 0.0700 1.865000 0.0700 1.865005 0.1700 1.867000 0.1700 1.867005 0.0700 1.869000 0.0700 1.869005 0.1700 1.871000 0.1700 1.871005 0.0700 1.873000 0.0700 1.873005 0.1700 1.875000 0.1700 1.875005 0.0700 1.877000 0.0700 1.877005 0.1700 1.879000 0.1700 1.879005 0.0700 1.881000 0.0700 1.881005 0.1700 1.883000 0.1700 1.883005 0.0700 1.885000 0.0700 1.885005 0.1700 1.887000 0.1700 1.887005 0.0700 1.889000 0.0700 1.889005 0.1700 1.891000 0.1700 1.891005 0.0700 1.893000 0.0700 1.893005 0.1700 1.895000 0.1700 1.895005 0.0700 1.897000 0.0700 1.897005 0.1700 1.899000 0.1700 1.899005 0.0700 1.901000 0.0700 1.901005 0.1700 1.903000 0.1700 1.903005 0.0700 1.905000 0.0700 1.905005 0.1700 1.907000 0.1700 1.907005 0.0700 1.909000 0.0700 1.909005 0.1700 1.911000 0.1700 1.911005 0.0700 1.913000 0.0700 1.913005 0.1700 1.915000 0.1700 1.915005 0.0700 1.917000 0.0700 1.917005 0.1700 1.919000 0.1700 1.919005 0.0700 1.921000 0.0700 1.921005 0.1700 1.923000 0.1700 1.923005 0.0700 1.925000 0.0700 1.925005 0.1700 1.927000 0.1700 1.927005 0.0700 1.929000 0.0700 1.929005 0.1700 1.931000 0.1700 1.931005 0.0700 1.933000 0.0700 1.933005 0.1700 1.935000 0.1700 1.935005 0.0700 1.937000 0.0700 1.937005 0.1700 1.939000 0.1700 1.939005 0.0700 1.941000 0.0700 1.941005 0.1700 1.943000 0.1700 1.943005 0.0700 1.945000 0.0700 1.945005 0.1700 1.947000 0.1700 1.947005 0.0700 1.949000 0.0700 1.949005 0.1700 1.951000 0.1700 1.951005 0.0700 1.953000 0.0700 1.953005 0.1700 1.955000 0.1700 1.955005 0.0700 1.957000 0.0700 1.957005 0.1700 1.959000 0.1700 1.959005 0.0700 1.961000 0.0700 1.961005 0.1700 1.963000 0.1700 1.963005 0.0700 1.965000 0.0700 1.965005 0.1700 1.967000 0.1700 1.967005 0.0700 1.969000 0.0700 1.969005 0.1700 1.971000 0.1700 1.971005 0.0700 1.973000 0.0700 1.973005 0.1700 1.975000 0.1700 1.975005 0.0700 1.977000 0.0700 1.977005 0.1700 1.979000 0.1700 1.979005 0.0700 1.981000 0.0700 1.981005 0.1700 1.983000 0.1700 1.983005 0.0700 1.985000 0.0700 1.985005 0.1700 1.987000 0.1700 1.987005 0.0700 1.989000 0.0700 1.989005 0.1700 1.991000 0.1700 1.991005 0.0700 1.993000 0.0700 1.993005 0.1700 1.995000 0.1700 1.995005 0.0700)
.ic v(gb)=4.8 v(v33)=0
.options method=gear reltol=1e-3
.tran 20u 2.0 0 20u uic
.control
run
wrdata /Users/hazymacmini/Projects/wifi-game-boy-cartridge/sim/power/out/old_ESP8266_stress_50pct_weak.dat v(gb) v(v33)
quit
.endc
.end
